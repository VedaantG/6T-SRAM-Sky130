** sch_path: /home/vedaant/Desktop/VLSI/SRAM/schematics/schematics.sch
.subckt schematics BL VDD GND BLB WL
*.iopin BL
*.ipin VDD
*.ipin GND
*.iopin BLB
*.iopin WL
XM2 net1 net2 VDD VDD sky130_fd_pr__pfet_01v8 L=0.15 W=0.42 nf=1 ad=0.1218 as=0.1218 pd=1.42 ps=1.42 nrd=0.69047619047619
+ nrs=0.69047619047619 sa=0 sb=0 sd=0 mult=1
XM4 net2 net1 VDD VDD sky130_fd_pr__pfet_01v8 L=0.15 W=0.42 nf=1 ad=0.1218 as=0.1218 pd=1.42 ps=1.42 nrd=0.69047619047619
+ nrs=0.69047619047619 sa=0 sb=0 sd=0 mult=1
XM1 net1 net2 GND GND sky130_fd_pr__nfet_01v8 L=0.15 W=0.84 nf=1 ad=0.2436 as=0.2436 pd=2.26 ps=2.26 nrd=0.345238095238095
+ nrs=0.345238095238095 sa=0 sb=0 sd=0 mult=1
XM3 BL WL net1 GND sky130_fd_pr__nfet_01v8 L=0.15 W=0.63 nf=1 ad=0.1827 as=0.1827 pd=1.84 ps=1.84 nrd=0.46031746031746
+ nrs=0.46031746031746 sa=0 sb=0 sd=0 mult=1
XM5 net2 WL BLB GND sky130_fd_pr__nfet_01v8 L=0.15 W=0.63 nf=1 ad=0.1827 as=0.1827 pd=1.84 ps=1.84 nrd=0.46031746031746
+ nrs=0.46031746031746 sa=0 sb=0 sd=0 mult=1
XM6 net2 net1 GND GND sky130_fd_pr__nfet_01v8 L=0.15 W=0.84 nf=1 ad=0.2436 as=0.2436 pd=2.26 ps=2.26 nrd=0.345238095238095
+ nrs=0.345238095238095 sa=0 sb=0 sd=0 mult=1
**** begin user architecture code

.lib /usr/local/share/pdk/sky130A/libs.tech/ngspice/sky130.lib.spice tt

**** end user architecture code
.ends
.end
